* File: yamaha-ca-800-phono.cir
.title Yamaha CA800 II phono netlist
R439 /TR405E Net-_C411-Pad1_ 47
R429 /TR407E 0 2.2k
R427 Net-_R411-Pad2_ 0 330
C411 Net-_C411-Pad1_ 0 47u
R425 Net-_C411-Pad1_ Net-_R411-Pad2_ 1.5k
R411 /TR401B Net-_R411-Pad2_ 220k
QTR401 /TR401C_TR403B /TR401B /TR401E KSC1845F
R409 /TR401E 0 470
R413 /TR403E_TR405B 0 4.7k
QTR403 /TR403C_TR405C_TR407B /TR401C_TR403B /TR403E_TR405B KSC1845F
R407 SUP /TR401C_TR403B 470k
C409 /TR401C_TR403B /TR403C_TR405C_TR407B 47p
Rcart1 IN Net-_Lcart1-Pad1_ 800
Lcart1 Net-_Lcart1-Pad1_ Net-_C401-Pad1_ 400m
R201 Net-_C401-Pad1_ 0 100k
R401 Net-_C401-Pad1_ 0 820k
R403 Net-_C401-Pad2_ 0 220k
Ccable1 Net-_C401-Pad1_ 0 140p
C401 Net-_C401-Pad1_ Net-_C401-Pad2_ 10u
C415 Net-_C413-Pad2_ Net-_C415-Pad2_ 18000p
R443 Net-_C419-Pad1_ /TR407E 220
R417 Net-_C413-Pad2_ Net-_C419-Pad1_ 180k
C419 Net-_C419-Pad1_ Net-_C415-Pad2_ 1u
R441 Net-_C425-Pad2_ 0 27k
C425 Net-_C425-Pad1_ Net-_C425-Pad2_ 10u
C413 /TR401E Net-_C413-Pad2_ 5000p
R415 /TR401E Net-_C413-Pad2_ 15k
QTR407 /TR407C /TR403C_TR405C_TR407B /TR407E TTC004B
R433 Net-_C415-Pad2_ 0 100k
R431 SUP /TR407C 10
QTR405 /TR403C_TR405C_TR407B /TR403E_TR405B /TR405E KSC1845F
R423 SUP /TR403C_TR405C_TR407B 4.7k
R421 /TR401E Net-_C425-Pad1_ 27k
C403 Net-_C403-Pad1_ Net-_C401-Pad2_ 4.7u
C407 /TR401B /TR401E 47p
R405 Net-_C403-Pad1_ Net-_C405-Pad2_ 1k
R419 Net-_C405-Pad2_ /TR401B 1.2k
C405 0 Net-_C405-Pad2_ 3p
C417 /TR407C 0 0.1u
R435 /TR407E Net-_C421-Pad1_ 2.2k
C421 Net-_C421-Pad1_ OUT 1u
Rload1 OUT 0 100k
.end
