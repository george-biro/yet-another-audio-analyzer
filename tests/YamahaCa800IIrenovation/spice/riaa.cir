.title KiCad schematic
R417 Net-_C413-Pad2_ Net-_C419-Pad1_ 180k
C415 Net-_C413-Pad2_ Net-_C415-Pad2_ 18000p
C413 OUT Net-_C413-Pad2_ 5000p
R415 OUT Net-_C413-Pad2_ 15k

R433 Net-_C415-Pad2_ GND 100k
R441 Net-_C425-Pad2_ GND 27k
R421 OUT Net-_C425-Pad1_ 27k
C425 Net-_C425-Pad1_ Net-_C425-Pad2_ 1u
*C419 Net-_C419-Pad1_ Net-_C415-Pad2_ 4.7u
C419 Net-_C419-Pad1_ Net-_C415-Pad2_ 1u
R443 Net-_C419-Pad1_ IN 220
R409 OUT GND 470

* Input voltage source
V1 IN 0 AC 1

* AC analysis
.ac dec 100 10 50k

* Control block for writing CSV
.control
run
set filetype=ascii
* Write VOUT and VIN only
wrdata yamaha_ac.csv frequency v(OUT) v(IN)
quit
.endc

.end
